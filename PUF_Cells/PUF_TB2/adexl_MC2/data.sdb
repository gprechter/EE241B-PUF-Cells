ADE simulation setup
Run mode: Monte Carlo Sampling
Tests:
  PUF_Cells:PUF_TB2:1: PUF_Cells/PUF_TB2/schematic, simulator spectre
Global variables (all switched off):
  CL = 0
  tmv = 16
  Tclk = 0.5n
  tsim = 10*tmv*Tclk + 2n
Monte Carlo Sampling options: mcmethod=mismatch, mcnumpoints=4
