ADE simulation setup
Run mode: Monte Carlo Sampling
Tests:
  PUF_Cells:PUF_Vth_TB:1: PUF_Cells/PUF_Vth_TB/schematic, simulator spectre
Global variables (all switched off):
  tsim = 50n
  Tclk = 500p
Monte Carlo Sampling options: mcmethod=mismatch, mcnumpoints=128
