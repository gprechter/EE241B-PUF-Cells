ADE simulation setup
Run mode: Monte Carlo Sampling
Tests:
  PUF_Cells:PUF_TB:1: PUF_Cells/PUF_TB/schematic, simulator spectre
Global variables:
  CL = 0
  tmv = 16
  Tclk = 2n
  tsim = 5*tmv*Tclk + 2n
Monte Carlo Sampling options: mcmethod=all, mcnumpoints=16
