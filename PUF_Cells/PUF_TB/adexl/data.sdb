ADE simulation setup
Run mode: Monte Carlo Sampling
Tests:
  PUF_Cells:PUF_TB:1: PUF_Cells/PUF_TB/schematic, simulator spectre
Global variables:
  CL = 0
Monte Carlo Sampling options: mcmethod=all, mcnumpoints=10
